* boardforge SPICE path gate: ALIAS-A
.option rshunt=1e9
.subckt opamp_OPA2810IDR inp inn out vcc vee
* Behavioral model for opamp_OPA2810IDR
* GBW=70.0MHz, SR=192.0V/us, Vos=0mV, Aol=100.0dB
* Source: kicad-happy part library (Phase 2)
*
* Input stage
Rin inp inn 1T
* Vos ≈ 0
*
* Gain stage: Aol=100000, pole at 700.0Hz → GBW=70.0MHz
E1 int 0 inp inn 100000
R1 int out_int 1
C1 out_int 0 227.4u
*
* Output stage with rail clamping
* Rail-to-rail output
Dhigh out_int vcc_int DLIMIT
Dlow vee_int out_int DLIMIT
Vswh vcc vcc_int DC 0
Vswl vee_int vee DC 0
.model DLIMIT D(IS=1e-14 N=0.01)
Eout out 0 out_int 0 1
.ends opamp_OPA2810IDR

.subckt opamp_OPA810IDBVR inp inn out vcc vee
* Behavioral model for opamp_OPA810IDBVR
* GBW=70.0MHz, SR=200.0V/us, Vos=0mV, Aol=100.0dB
* Source: kicad-happy part library (Phase 2)
*
* Input stage
Rin inp inn 1T
* Vos ≈ 0
*
* Gain stage: Aol=100000, pole at 700.0Hz → GBW=70.0MHz
E1 int 0 inp inn 100000
R1 int out_int 1
C1 out_int 0 227.4u
*
* Output stage with rail clamping
* Rail-to-rail output
Dhigh out_int vcc_int DLIMIT
Dlow vee_int out_int DLIMIT
Vswh vcc vcc_int DC 0
Vswl vee_int vee DC 0
.model DLIMIT D(IS=1e-14 N=0.01)
Eout out 0 out_int 0 1
.ends opamp_OPA810IDBVR

.subckt fda_THS4551IRGTR inp inn outp outn vocm vcc vee
* Behavioral FDA (boardforge): GBW=135.0MHz, Aol=100.0dB
Rin inp inn 1e9
E1 d 0 inp inn 100000
R1 d dp 1
C1 dp 0 0.000117893
Bp outp 0 V=V(vocm)+V(dp)/2
Bn outn 0 V=V(vocm)-V(dp)/2
.ends fda_THS4551IRGTR

CC1001 n_p1V2 0 1e-07
CC1002 n_p1V2 0 1e-07
CC1003 n_p1V2 0 1e-07
CC1004 n_p1V2 0 1e-07
CC1005 n_p1V2 0 1e-07
CC1006 n_p3V3 0 1e-07
CC1007 n_p3V3 0 1e-07
CC1008 n_p3V3 0 1e-07
CC1009 n_p3V3 0 1e-07
CC101 n_VIN_A n_ATT_A 8.2e-12
CC1010 n_p3V3 0 1e-07
CC1011 n_p3V3 0 1e-07
CC1012 n_p3V3 0 1e-07
CC1013 n_p3V3 0 1e-07
CC1014 n_p3V3 0 1e-07
CC1015 n_p3V3 0 1e-07
CC1016 n_p3V3 0 1e-07
CC1017 n_p3V3 0 1e-07
CC1018 n_p3V3 0 1e-07
CC1019 n_p3V3 0 1e-07
CC102 n_VIN_A n_ATT_A 3.3e-12
CC1020 n_p3V3 0 1e-07
CC1021 n_p3V3 0 1e-07
CC1022 n_p3V3 0 1e-07
CC1023 n_p1V2 0 4.7e-06
CC1024 n_p3V3 0 4.7e-06
CC1025 n_p3V3 0 4.7e-06
CC103 n_ATT_A 0 2.2e-10
CC104 n_SKA1_A n_SKA_A 2.7e-10
CC105 n_SKA2_A 0 1e-10
CC106 n_SKB1_A n_SKB_A 1.8e-09
CC107 n_SKB2_A 0 8.2e-11
CC108 n_MFX_P_A 0 3.3e-10
CC109 n_MFX_N_A 0 3.3e-10
CC110 n_FDA_INP_A n_FDA_OUTN_A 8.2e-11
CC111 n_FDA_INN_A n_FDA_OUTP_A 8.2e-11
CC112 n_AIN_AP n_AIN_AN 1.2e-09
CC113 n_p4V0A 0 1e-07
CC114 n_m4V0A 0 1e-07
CC115 n_p4V0A 0 1e-07
CC116 n_m4V0A 0 1e-07
CC117 n_p3V3A 0 1e-07
CC118 n_p3V3A 0 1e-06
CC119 n_ADC_CM 0 1e-08
CC120 n_p4V0A 0 2.2e-06
CC121 n_m4V0A 0 2.2e-06
CC201 n_VIN_B n_ATT_B 8.2e-12
CC202 n_VIN_B n_ATT_B 3.3e-12
CC203 n_ATT_B 0 2.2e-10
CC204 n_SKA1_B n_SKA_B 2.7e-10
CC205 n_SKA2_B 0 1e-10
CC206 n_SKB1_B n_SKB_B 1.8e-09
CC207 n_SKB2_B 0 8.2e-11
CC208 n_MFX_P_B 0 3.3e-10
CC209 n_MFX_N_B 0 3.3e-10
CC210 n_FDA_INP_B n_FDA_OUTN_B 8.2e-11
CC211 n_FDA_INN_B n_FDA_OUTP_B 8.2e-11
CC212 n_AIN_BP n_AIN_BN 1.2e-09
CC213 n_p4V0A 0 1e-07
CC214 n_m4V0A 0 1e-07
CC215 n_p4V0A 0 1e-07
CC216 n_m4V0A 0 1e-07
CC217 n_p3V3A 0 1e-07
CC218 n_p3V3A 0 1e-06
CC219 n_ADC_CM 0 1e-08
CC220 n_p4V0A 0 2.2e-06
CC221 n_m4V0A 0 2.2e-06
CC301 n_REFT_RC 0 1e-07
CC302 n_REFB_RC 0 1e-07
CC303 n_ADC_CM 0 1e-07
CC304 n_ADC_CM 0 1e-06
CC305 n_p3V3A 0 1e-07
CC306 n_p3V3A 0 1e-07
CC307 n_p3V3A 0 1e-07
CC308 n_p3V3A 0 4.7e-06
CC309 n_p3V3_ADCIO 0 1e-07
CC310 n_p3V3_ADCIO 0 1e-07
CC311 n_p3V3_ADCIO 0 1e-07
CC312 n_p3V3_ADCIO 0 1e-07
CC313 n_p3V3_ADCIO 0 4.7e-06
CC401 n_p3V3_CLK 0 1e-07
CC402 n_p3V3_CLK 0 1e-07
CC403 n_p3V3_CLK 0 4.7e-06
CC501 n_VBUS 0 1e-06
CC601 n_p5V 0 4.7e-06
CC602 n_p3V3 0 1e-05
CC603 n_p3V3 0 1e-05
CC604 n_p3V3 n_FB_3V3 6.8e-12
CC605 n_p3V3 0 1e-06
CC606 n_p1V2 0 1e-06
CC702 n_p5VA 0 1e-06
CC703 n_p3V3A 0 1e-06
CC705 n_p5VA 0 2.2e-06
CC706 n_LM_C1P n_LM_C1N 1e-06
CC707 n_LM_CP 0 4.7e-06
CC708 n_p4V0A 0 2.2e-06
CC709 n_m4V0A 0 2.2e-06
CC801 n_p3V3 0 1e-07
CC802 n_p3V3 0 1e-07
CC803 n_p3V3 0 1e-07
CC804 n_p3V3 0 1e-07
CC805 n_p3V3 0 1e-07
CC806 n_p3V3 0 1e-07
CC807 n_p3V3 0 1e-07
CC808 n_p3V3 0 1e-05
CC901 n_FT_XI 0 1.8e-11
CC902 n_FT_XO 0 1.8e-11
CC903 n_p3V3_PHY 0 4.7e-06
CC904 n_p3V3_PHY 0 1e-07
CC905 n_p3V3_PHY 0 1e-07
CC906 n_p3V3 0 1e-07
CC907 n_p3V3 0 1e-07
CC908 n_p3V3 0 1e-07
CC909 n_p3V3 0 4.7e-06
CC910 n_p3V3 0 1e-07
CC911 n_FT_VCORE 0 1e-07
CC912 n_FT_VCCA 0 1e-07
CC913 n_p3V3 0 1e-07
RF501 n_VBUS n_p5V 0.05
RFB301 n_p3V3 n_p3V3_ADCIO 0.05
RFB401 n_p3V3 n_p3V3_CLK 0.05
RFB701 n_p5V n_p5VA 0.05
RFB901 n_p3V3 n_p3V3_PHY 0.05
LL601 n_SW_3V3 n_p3V3 2.2e-06
RR1001 n_CFG_CS_N n_p3V3 4700
RR1002 n_FL_WP_N n_p3V3 10000
RR1003 n_FL_HOLD_N n_p3V3 10000
RR1004 n_CFG_PROG_N n_p3V3 4700
RR1005 n_CFG_INIT_N n_p3V3 4700
RR1006 n_CFG_DONE n_p3V3 330
RR1008 n_CFG_M1 0 1000
RR1009 n_CFG_M0 n_p3V3 1000
RR101 n_VIN_A n_ATT_A 953000
RR1010 n_CFG_HSWAPEN n_p3V3 1000
RR1012 n_LED_ARMED n_LED_ARMED_A 1000
RR1013 n_LED_TRIG n_LED_TRIG_A 1000
RR1014 n_TRIG_IN n_TRIG_IN_F 100
RR1015 n_TRIG_IN 0 10000
RR1016 n_TRIG_OUT_F n_TRIG_OUT 100
RR102 n_ATT_A 0 49900
RR103 n_ATT_A n_BUFIN_A 1000
RR104 n_BUF_A n_SKA1_A 887
RR105 n_SKA1_A n_SKA2_A 453
RR106 n_SKA_A n_SKB1_A 374
RR107 n_SKB1_A n_SKB2_A 232
RR108 n_SKB_A n_MFX_P_A 698
RR109 0 n_MFX_N_A 698
RR110 n_MFX_P_A n_FDA_OUTN_A 1270
RR111 n_MFX_N_A n_FDA_OUTP_A 1270
RR112 n_MFX_P_A n_FDA_INP_A 576
RR113 n_MFX_N_A n_FDA_INN_A 576
RR114 n_FDA_OUTP_A n_AIN_AP 46.4
RR115 n_FDA_OUTN_A n_AIN_AN 46.4
RR201 n_VIN_B n_ATT_B 953000
RR202 n_ATT_B 0 49900
RR203 n_ATT_B n_BUFIN_B 1000
RR204 n_BUF_B n_SKA1_B 887
RR205 n_SKA1_B n_SKA2_B 453
RR206 n_SKA_B n_SKB1_B 374
RR207 n_SKB1_B n_SKB2_B 232
RR208 n_SKB_B n_MFX_P_B 698
RR209 0 n_MFX_N_B 698
RR210 n_MFX_P_B n_FDA_OUTN_B 1270
RR211 n_MFX_N_B n_FDA_OUTP_B 1270
RR212 n_MFX_P_B n_FDA_INP_B 576
RR213 n_MFX_N_B n_FDA_INN_B 576
RR214 n_FDA_OUTP_B n_AIN_BP 46.4
RR215 n_FDA_OUTN_B n_AIN_BN 46.4
RR301 n_ADC_ISET 0 56200
RR302 n_ADC_REFT n_REFT_RC 2
RR303 n_ADC_REFB n_REFB_RC 2
RR304 n_ADC_SEL 0 10000
RR305 n_ADC_SEN 0 10000
RR306 n_ADC_SCLK 0 10000
RR307 n_ADC_SDATA 0 10000
RR401 n_CLKB1 n_ADC_CLK 33
RR402 n_CLKB2 n_CLK10_FPGA 33
RR501 n_CC1 0 5100
RR502 n_CC2 0 5100
RR601 n_p3V3 n_FB_3V3 453000
RR602 n_FB_3V3 0 100000
RR604 n_p3V3 n_LED_PWR 1000
RR701 n_p4V0A n_LM_FBP 232000
RR702 n_LM_FBP 0 100000
RR703 n_m4V0A n_LM_FBN 226000
RR704 n_LM_FBN 0 100000
RR705 n_p4V0A n_LM_PGOOD 100000
RR801 n_SD_CLK n_SD_CLK_M 22
RR802 n_SD_CKE 0 10000
RR803 n_SD_CS_N n_p3V3 10000
RR901 n_FT_REF 0 12000
RR902 n_FT_RESET_N n_p3V3 10000
RR903 n_EE_DO n_EE_DATA 2200
RR904 n_EE_CS n_p3V3 10000
RR905 n_EE_CLK n_p3V3 10000
RR906 n_EE_DATA n_p3V3 10000
RR907 n_FT_RD_N n_p3V3 10000
RR908 n_FT_WR_N n_p3V3 10000
RR909 n_FT_SIWU_N n_p3V3 10000
RR910 n_FT_CLKOUT_S n_FT_CLKOUT 22
RR911 n_FT_OE_N n_p3V3 10000
RR912 n_FT_PWRSAV_N n_p3V3 10000
XU101_A n_BUFIN_A n_BUF_A n_BUF_A n_p4V0A n_m4V0A opamp_OPA2810IDR
XU101_B n_SKA2_A n_SKA_A n_SKA_A n_p4V0A n_m4V0A opamp_OPA2810IDR
XU102 n_SKB2_A n_SKB_A n_SKB_A n_p4V0A n_m4V0A opamp_OPA810IDBVR
XU103 n_FDA_INP_A n_FDA_INN_A n_FDA_OUTP_A n_FDA_OUTN_A n_ADC_CM n_p3V3A 0 fda_THS4551IRGTR
XU201_A n_BUFIN_B n_BUF_B n_BUF_B n_p4V0A n_m4V0A opamp_OPA2810IDR
XU201_B n_SKA2_B n_SKA_B n_SKA_B n_p4V0A n_m4V0A opamp_OPA2810IDR
XU202 n_SKB2_B n_SKB_B n_SKB_B n_p4V0A n_m4V0A opamp_OPA810IDBVR
XU203 n_FDA_INP_B n_FDA_INN_B n_FDA_OUTP_B n_FDA_OUTN_B n_ADC_CM n_p3V3A 0 fda_THS4551IRGTR
V_p1V2 n_p1V2 0 DC 1.2
V_p3V3 n_p3V3 0 DC 3.3
V_p3V3A n_p3V3A 0 DC 3.3
V_p3V3_ADCIO n_p3V3_ADCIO 0 DC 3.3
V_p3V3_CLK n_p3V3_CLK 0 DC 3.3
V_p3V3_PHY n_p3V3_PHY 0 DC 3.3
V_p4V0A n_p4V0A 0 DC 4
V_p5V n_p5V 0 DC 5
V_p5VA n_p5VA 0 DC 5
V_m4V0A n_m4V0A 0 DC -4
V_FT_VCCA n_FT_VCCA 0 DC 0
V_FT_VCORE n_FT_VCORE 0 DC 0
V_SW_3V3 n_SW_3V3 0 DC 0
V_VBUS n_VBUS 0 DC 5
VSIG n_VIN_A 0 DC 0 AC 1
.control
ac dec 200 1 5e+07
let gdb = db(v(n_AIN_AP)-v(n_AIN_AN))
meas ac g_at find gdb at=5e+06
meas ac g_ref find gdb at=1000
.endc
.end
